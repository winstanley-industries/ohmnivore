EMI-01 v1 heavy nominal
.include model.lib
Vbus bus 0 400
Rbus bus p1 0.02
Lbus p1 p 20n
Cbus p1 0 10u
Vdah p ahd 0
Xdah ahd gah a MSC040SMA120B PARAMS: TJ_C=27
Vdal a ald 0
Xdal ald ga 0 MSC040SMA120B PARAMS: TJ_C=27
Vgah driveah a PULSE(-3 20 1u 10n 10n 1.4800000000000001e-05 20u)
Vgal driveal 0 PULSE(20 -3 0.8u 10n 10n 1.52e-05 20u)
Rgah driveah gah 4.7000000000000002
Rgal driveal ga 4.7000000000000002
Cswa a ch 1e-10
Rda a ar 0.0089648000000000002
Lda ar am 4.6999999999999997e-05
Rcma am amr 0.0062064000000000008
Lcma amr fa 0.00046999999999999999
Cwinda amr fa 9.9999999999999994e-12
Rya fa yca 22
Cya yca ch 4.6999999999999999e-09
Va fa ha 0
Rha ha har 0.1
Lha har la 1u
Cha la ch 2.0000000000000001e-10
Cla la ch 1.0000000000000001e-09
Vdbh p bhd 0
Xdbh bhd gbh b MSC040SMA120B PARAMS: TJ_C=27
Vdbl b bld 0
Xdbl bld gb 0 MSC040SMA120B PARAMS: TJ_C=27
Vgbh drivebh b PULSE(-3 20 1u 10n 10n 4.7999999999999998e-06 20u)
Vgbl drivebl 0 PULSE(20 -3 0.8u 10n 10n 5.1999999999999993e-06 20u)
Rgbh drivebh gbh 4.7000000000000002
Rgbl drivebl gb 4.7000000000000002
Cswb b ch 1e-10
Rdb b br 0.0089648000000000002
Ldb br bm 4.6999999999999997e-05
Rcmb bm bmr 0.0062064000000000008
Lcmb bmr fb 0.00046999999999999999
Cwindb bmr fb 9.9999999999999994e-12
Ryb fb ycb 22
Cyb ycb ch 4.6999999999999999e-09
Vb fb hb 0
Rhb hb hbr 0.1
Lhb hbr lb 1u
Chb lb ch 2.0000000000000001e-10
Clb lb ch 1.0000000000000001e-09
Kcm Lcma Lcmb 0.995
Kh Lha Lhb 0.2
Ccouple fa fb 4.9999999999999997e-12
Rx fa xcap 0.2
Cx xcap fb 2.2000000000000001e-07
Rload la lr 20
Lload lr lb 100u
Rloadloss lr lb 100
Rch ch chr 1
Lch chr 0 50n
Cbp p ch 1e-10
Cbn 0 ch 1e-10
.options reltol=1e-5 abstol=1e-9 vntol=1e-7 chgtol=1e-16 method=gear maxord=2 itl1=300 itl4=100
.tran 1.5625e-10 200u 0 3.1250000000000001e-10
.save v(a) v(b) v(ch) v(fa) v(fb) v(ga) v(gb) v(la) v(lb) i(lch) i(lcma) i(lcmb) i(lda) i(ldb) i(lload) v(lr) v(p) i(va) i(vb) i(vdah) i(vdal) i(vdbh) i(vdbl) v(xcap) v(yca) v(ycb)
.end
