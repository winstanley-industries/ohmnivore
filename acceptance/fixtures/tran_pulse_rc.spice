* Phase 2C hermetic ngspice acceptance: pulsed RC filter
V1 in 0 PULSE(0 5 0 1u 1u 0.5m 1m)
R1 in out 1k
C1 out 0 1u
.TRAN 1u 2m 0 UIC
.END
