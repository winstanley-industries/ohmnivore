* EMI-02A coupled-element oracle: unequal windings with positive dots.
V1 p 0 AC 1
R1 p a 2
L1 a 0 2m
V2 q 0 AC 0.3 180
R2 q b 3
L2 b 0 8m
K1 L1 L2 0.995
.AC LIN 31 20 50k
.END
